LUT with two inputs, sram
.model __Q1 NMOS vto=1 kp=1m gamma=0.4 phi=0.65 lambda=0.02 cbd=0.5p cbs=0.5p cgso=10n cgdo=10n
.model __Q2 NMOS vto=1 kp=1m gamma=0.4 phi=0.65 lambda=0.02 cbd=0.5p cbs=0.5p cgso=10n cgdo=10n
.model __Q4 NMOS vto=1 kp=1m gamma=0.4 phi=0.65 lambda=0.02 cbd=0.5p cbs=0.5p cgso=10n cgdo=10n
.model __Q3 PMOS vto=-1 kp=0.5m gamma=0.4 phi=0.65 lambda=0.02 cbd=0.5p cbs=0.5p cgso=10n cgdo=10n
.model __Q6 NMOS vto=1 kp=1m gamma=0.4 phi=0.65 lambda=0.02 cbd=0.5p cbs=0.5p cgso=10n cgdo=10n
.model __Q5 PMOS vto=-1 kp=0.5m gamma=0.4 phi=0.65 lambda=0.02 cbd=0.5p cbs=0.5p cgso=10n cgdo=10n
.model __Q7 NMOS vto=1 kp=1m gamma=0.4 phi=0.65 lambda=0.02 cbd=0.5p cbs=0.5p cgso=10n cgdo=10n
.model __Q8 NMOS vto=1 kp=1m gamma=0.4 phi=0.65 lambda=0.02 cbd=0.5p cbs=0.5p cgso=10n cgdo=10n
.model __Q10 NMOS vto=1 kp=1m gamma=0.4 phi=0.65 lambda=0.02 cbd=0.5p cbs=0.5p cgso=10n cgdo=10n
.model __Q9 PMOS vto=-1 kp=0.5m gamma=0.4 phi=0.65 lambda=0.02 cbd=0.5p cbs=0.5p cgso=10n cgdo=10n
.model __Q12 NMOS vto=1 kp=1m gamma=0.4 phi=0.65 lambda=0.02 cbd=0.5p cbs=0.5p cgso=10n cgdo=10n
.model __Q11 PMOS vto=-1 kp=0.5m gamma=0.4 phi=0.65 lambda=0.02 cbd=0.5p cbs=0.5p cgso=10n cgdo=10n
.model __Q13 NMOS vto=1 kp=1m gamma=0.4 phi=0.65 lambda=0.02 cbd=0.5p cbs=0.5p cgso=10n cgdo=10n
.model __Q14 NMOS vto=1 kp=1m gamma=0.4 phi=0.65 lambda=0.02 cbd=0.5p cbs=0.5p cgso=10n cgdo=10n
.model __Q16 NMOS vto=1 kp=1m gamma=0.4 phi=0.65 lambda=0.02 cbd=0.5p cbs=0.5p cgso=10n cgdo=10n
.model __Q15 PMOS vto=-1 kp=0.5m gamma=0.4 phi=0.65 lambda=0.02 cbd=0.5p cbs=0.5p cgso=10n cgdo=10n
.model __Q18 NMOS vto=1 kp=1m gamma=0.4 phi=0.65 lambda=0.02 cbd=0.5p cbs=0.5p cgso=10n cgdo=10n
.model __Q17 PMOS vto=-1 kp=0.5m gamma=0.4 phi=0.65 lambda=0.02 cbd=0.5p cbs=0.5p cgso=10n cgdo=10n
.model __Q19 NMOS vto=1 kp=1m gamma=0.4 phi=0.65 lambda=0.02 cbd=0.5p cbs=0.5p cgso=10n cgdo=10n
.model __Q20 NMOS vto=1 kp=1m gamma=0.4 phi=0.65 lambda=0.02 cbd=0.5p cbs=0.5p cgso=10n cgdo=10n
.model __Q22 NMOS vto=1 kp=1m gamma=0.4 phi=0.65 lambda=0.02 cbd=0.5p cbs=0.5p cgso=10n cgdo=10n
.model __Q21 PMOS vto=-1 kp=0.5m gamma=0.4 phi=0.65 lambda=0.02 cbd=0.5p cbs=0.5p cgso=10n cgdo=10n
.model __Q24 NMOS vto=1 kp=1m gamma=0.4 phi=0.65 lambda=0.02 cbd=0.5p cbs=0.5p cgso=10n cgdo=10n
.model __Q23 PMOS vto=-1 kp=0.5m gamma=0.4 phi=0.65 lambda=0.02 cbd=0.5p cbs=0.5p cgso=10n cgdo=10n
.model __Q26 NMOS vto=1 kp=1m gamma=0.4 phi=0.65 lambda=0.02 cbd=0.5p cbs=0.5p cgso=10n cgdo=10n
.model __Q25 PMOS vto=-1 kp=0.5m gamma=0.4 phi=0.65 lambda=0.02 cbd=0.5p cbs=0.5p cgso=10n cgdo=10n
.model __Q28 NMOS vto=1 kp=1m gamma=0.4 phi=0.65 lambda=0.02 cbd=0.5p cbs=0.5p cgso=10n cgdo=10n
.model __Q27 PMOS vto=-1 kp=0.5m gamma=0.4 phi=0.65 lambda=0.02 cbd=0.5p cbs=0.5p cgso=10n cgdo=10n
.model __Q29 NMOS vto=1 kp=1m gamma=0.4 phi=0.65 lambda=0.02 cbd=0.5p cbs=0.5p cgso=10n cgdo=10n
.model __Q30 PMOS vto=-1 kp=0.5m gamma=0.4 phi=0.65 lambda=0.02 cbd=0.5p cbs=0.5p cgso=10n cgdo=10n
.model __Q31 NMOS vto=1 kp=1m gamma=0.4 phi=0.65 lambda=0.02 cbd=0.5p cbs=0.5p cgso=10n cgdo=10n
.model __Q32 PMOS vto=-1 kp=0.5m gamma=0.4 phi=0.65 lambda=0.02 cbd=0.5p cbs=0.5p cgso=10n cgdo=10n
.model __Q33 NMOS vto=1 kp=1m gamma=0.4 phi=0.65 lambda=0.02 cbd=0.5p cbs=0.5p cgso=10n cgdo=10n
.model __Q34 PMOS vto=-1 kp=0.5m gamma=0.4 phi=0.65 lambda=0.02 cbd=0.5p cbs=0.5p cgso=10n cgdo=10n
.model __Q35 NMOS vto=1 kp=1m gamma=0.4 phi=0.65 lambda=0.02 cbd=0.5p cbs=0.5p cgso=10n cgdo=10n
.model __Q36 PMOS vto=-1 kp=0.5m gamma=0.4 phi=0.65 lambda=0.02 cbd=0.5p cbs=0.5p cgso=10n cgdo=10n
.model __Q37 NMOS vto=1 kp=1m gamma=0.4 phi=0.65 lambda=0.02 cbd=0.5p cbs=0.5p cgso=10n cgdo=10n
.model __Q38 PMOS vto=-1 kp=0.5m gamma=0.4 phi=0.65 lambda=0.02 cbd=0.5p cbs=0.5p cgso=10n cgdo=10n
.model __Q39 NMOS vto=1 kp=1m gamma=0.4 phi=0.65 lambda=0.02 cbd=0.5p cbs=0.5p cgso=10n cgdo=10n
.model __Q40 PMOS vto=-1 kp=0.5m gamma=0.4 phi=0.65 lambda=0.02 cbd=0.5p cbs=0.5p cgso=10n cgdo=10n
.model __Q42 NMOS vto=1 kp=1m gamma=0.4 phi=0.65 lambda=0.02 cbd=0.5p cbs=0.5p cgso=10n cgdo=10n
.model __Q41 PMOS vto=-1 kp=0.5m gamma=0.4 phi=0.65 lambda=0.02 cbd=0.5p cbs=0.5p cgso=10n cgdo=10n
.model __Q44 NMOS vto=1 kp=1m gamma=0.4 phi=0.65 lambda=0.02 cbd=0.5p cbs=0.5p cgso=10n cgdo=10n
.model __Q43 PMOS vto=-1 kp=0.5m gamma=0.4 phi=0.65 lambda=0.02 cbd=0.5p cbs=0.5p cgso=10n cgdo=10n
V4 bl 0 PWL(0 0 8.06e-07 0 8.07e-07 5 8.28e-07 5 8.29e-07 0 1.628e-06 0 1.629e-06 5 1.65e-06 5 1.651e-06 0 2.406e-06 0 2.407e-06 5 2.45e-06 5 2.451e-06 0 3.25e-06 0 3.251e-06 5 3.272e-06 5 3.273e-06 0 4.006e-06 0 4.007e-06 5 4.028e-06 5 4.029e-06 0 4.05e-06 0 4.051e-06 5 4.072e-06 5 4.073e-06 0 4.828e-06 0 4.829e-06 5 4.872e-06 5 4.873e-06 0 5.606e-06 0 5.607e-06 5 5.672e-06 5 5.673e-06 0 6.472e-06 0 6.473e-06 5 7.228e-06 5 7.229e-06 0 7.272e-06 0 7.273e-06 5 8.006e-06 5 8.007e-06 0 8.028e-06 0 8.029e-06 5 8.05e-06 5 8.051e-06 0 8.072e-06 0 8.073e-06 5 8.85e-06 5 8.851e-06 0 8.872e-06 0 8.873e-06 5 9.606e-06 5 9.607e-06 0 9.65e-06 0 9.651e-06 5 1.0428e-05 5 1.0429e-05 0 1.045e-05 0 1.0451e-05 5 1.1206e-05 5 1.1207e-05 0 1.1228e-05 0 1.1229e-05 5 1.28e-05 5)
V5 bln 0 PWL(0 5 8.06e-07 5 8.07e-07 0 8.28e-07 0 8.29e-07 5 1.628e-06 5 1.629e-06 0 1.65e-06 0 1.651e-06 5 2.406e-06 5 2.407e-06 0 2.45e-06 0 2.451e-06 5 3.25e-06 5 3.251e-06 0 3.272e-06 0 3.273e-06 5 4.006e-06 5 4.007e-06 0 4.028e-06 0 4.029e-06 5 4.05e-06 5 4.051e-06 0 4.072e-06 0 4.073e-06 5 4.828e-06 5 4.829e-06 0 4.872e-06 0 4.873e-06 5 5.606e-06 5 5.607e-06 0 5.672e-06 0 5.673e-06 5 6.472e-06 5 6.473e-06 0 7.228e-06 0 7.229e-06 5 7.272e-06 5 7.273e-06 0 8.006e-06 0 8.007e-06 5 8.028e-06 5 8.029e-06 0 8.05e-06 0 8.051e-06 5 8.072e-06 5 8.073e-06 0 8.85e-06 0 8.851e-06 5 8.872e-06 5 8.873e-06 0 9.606e-06 0 9.607e-06 5 9.65e-06 5 9.651e-06 0 1.0428e-05 0 1.0429e-05 5 1.045e-05 5 1.0451e-05 0 1.1206e-05 0 1.1207e-05 5 1.1228e-05 5 1.1229e-05 0 1.28e-05 0)
V7 wl1 0 PWL(0 0 3.1e-08 0 3.2e-08 5 4.5e-08 5 4.6e-08 0 8.31e-07 0 8.32e-07 5 8.45e-07 5 8.46e-07 0 1.631e-06 0 1.632e-06 5 1.645e-06 5 1.646e-06 0 2.431e-06 0 2.432e-06 5 2.445e-06 5 2.446e-06 0 3.231e-06 0 3.232e-06 5 3.245e-06 5 3.246e-06 0 4.031e-06 0 4.032e-06 5 4.045e-06 5 4.046e-06 0 4.831e-06 0 4.832e-06 5 4.845e-06 5 4.846e-06 0 5.631e-06 0 5.632e-06 5 5.645e-06 5 5.646e-06 0 6.431e-06 0 6.432e-06 5 6.445e-06 5 6.446e-06 0 7.231e-06 0 7.232e-06 5 7.245e-06 5 7.246e-06 0 8.031e-06 0 8.032e-06 5 8.045e-06 5 8.046e-06 0 8.831e-06 0 8.832e-06 5 8.845e-06 5 8.846e-06 0 9.631e-06 0 9.632e-06 5 9.645e-06 5 9.646e-06 0 1.0431e-05 0 1.0432e-05 5 1.0445e-05 5 1.0446e-05 0 1.1231e-05 0 1.1232e-05 5 1.1245e-05 5 1.1246e-05 0 1.2031e-05 0 1.2032e-05 5 1.2045e-05 5 1.2046e-05 0 1.28e-05 0)
V6 wl0 0 PWL(0 0 9e-09 0 1e-08 5 2.3e-08 5 2.4e-08 0 8.09e-07 0 8.1e-07 5 8.23e-07 5 8.24e-07 0 1.609e-06 0 1.61e-06 5 1.623e-06 5 1.624e-06 0 2.409e-06 0 2.41e-06 5 2.423e-06 5 2.424e-06 0 3.209e-06 0 3.21e-06 5 3.223e-06 5 3.224e-06 0 4.009e-06 0 4.01e-06 5 4.023e-06 5 4.024e-06 0 4.809e-06 0 4.81e-06 5 4.823e-06 5 4.824e-06 0 5.609e-06 0 5.61e-06 5 5.623e-06 5 5.624e-06 0 6.409e-06 0 6.41e-06 5 6.423e-06 5 6.424e-06 0 7.209e-06 0 7.21e-06 5 7.223e-06 5 7.224e-06 0 8.009e-06 0 8.01e-06 5 8.023e-06 5 8.024e-06 0 8.809e-06 0 8.81e-06 5 8.823e-06 5 8.824e-06 0 9.609e-06 0 9.61e-06 5 9.623e-06 5 9.624e-06 0 1.0409e-05 0 1.041e-05 5 1.0423e-05 5 1.0424e-05 0 1.1209e-05 0 1.121e-05 5 1.1223e-05 5 1.1224e-05 0 1.2009e-05 0 1.201e-05 5 1.2023e-05 5 1.2024e-05 0 1.28e-05 0)
V9 wl3 0 PWL(0 0 7.5e-08 0 7.6e-08 5 8.9e-08 5 9e-08 0 8.75e-07 0 8.76e-07 5 8.89e-07 5 8.9e-07 0 1.675e-06 0 1.676e-06 5 1.689e-06 5 1.69e-06 0 2.475e-06 0 2.476e-06 5 2.489e-06 5 2.49e-06 0 3.275e-06 0 3.276e-06 5 3.289e-06 5 3.29e-06 0 4.075e-06 0 4.076e-06 5 4.089e-06 5 4.09e-06 0 4.875e-06 0 4.876e-06 5 4.889e-06 5 4.89e-06 0 5.675e-06 0 5.676e-06 5 5.689e-06 5 5.69e-06 0 6.475e-06 0 6.476e-06 5 6.489e-06 5 6.49e-06 0 7.275e-06 0 7.276e-06 5 7.289e-06 5 7.29e-06 0 8.075e-06 0 8.076e-06 5 8.089e-06 5 8.09e-06 0 8.875e-06 0 8.876e-06 5 8.889e-06 5 8.89e-06 0 9.675e-06 0 9.676e-06 5 9.689e-06 5 9.69e-06 0 1.0475e-05 0 1.0476e-05 5 1.0489e-05 5 1.049e-05 0 1.1275e-05 0 1.1276e-05 5 1.1289e-05 5 1.129e-05 0 1.2075e-05 0 1.2076e-05 5 1.2089e-05 5 1.209e-05 0 1.28e-05 0)
V8 wl2 0 PWL(0 0 5.3e-08 0 5.4e-08 5 6.7e-08 5 6.8e-08 0 8.53e-07 0 8.54e-07 5 8.67e-07 5 8.68e-07 0 1.653e-06 0 1.654e-06 5 1.667e-06 5 1.668e-06 0 2.453e-06 0 2.454e-06 5 2.467e-06 5 2.468e-06 0 3.253e-06 0 3.254e-06 5 3.267e-06 5 3.268e-06 0 4.053e-06 0 4.054e-06 5 4.067e-06 5 4.068e-06 0 4.853e-06 0 4.854e-06 5 4.867e-06 5 4.868e-06 0 5.653e-06 0 5.654e-06 5 5.667e-06 5 5.668e-06 0 6.453e-06 0 6.454e-06 5 6.467e-06 5 6.468e-06 0 7.253e-06 0 7.254e-06 5 7.267e-06 5 7.268e-06 0 8.053e-06 0 8.054e-06 5 8.067e-06 5 8.068e-06 0 8.853e-06 0 8.854e-06 5 8.867e-06 5 8.868e-06 0 9.653e-06 0 9.654e-06 5 9.667e-06 5 9.668e-06 0 1.0453e-05 0 1.0454e-05 5 1.0467e-05 5 1.0468e-05 0 1.1253e-05 0 1.1254e-05 5 1.1267e-05 5 1.1268e-05 0 1.2053e-05 0 1.2054e-05 5 1.2067e-05 5 1.2068e-05 0 1.28e-05 0)
CL1 y 0 10p
V3 b 0 PULSE(0 5 4e-07 1e-09 1e-09 3.99e-07 8e-07)
V2 a 0 PULSE(0 5 2e-07 1e-09 1e-09 3.99e-07 8e-07)
V1 vdd 0 DC 5
MQ1 bl wl0 t0 0 __Q1 l=10u w=10u
MQ2 cell0_qn wl0 bln 0 __Q2 l=10u w=10u
MQ4 t0 cell0_qn 0 0 __Q4 l=10u w=10u
MQ3 t0 cell0_qn vdd vdd __Q3 l=10u w=10u
MQ6 cell0_qn t0 0 0 __Q6 l=10u w=10u
MQ5 cell0_qn t0 vdd vdd __Q5 l=10u w=10u
MQ7 bl wl1 t1 0 __Q7 l=10u w=10u
MQ8 cell1_qn wl1 bln 0 __Q8 l=10u w=10u
MQ10 t1 cell1_qn 0 0 __Q10 l=10u w=10u
MQ9 t1 cell1_qn vdd vdd __Q9 l=10u w=10u
MQ12 cell1_qn t1 0 0 __Q12 l=10u w=10u
MQ11 cell1_qn t1 vdd vdd __Q11 l=10u w=10u
MQ13 bl wl2 t2 0 __Q13 l=10u w=10u
MQ14 cell2_qn wl2 bln 0 __Q14 l=10u w=10u
MQ16 t2 cell2_qn 0 0 __Q16 l=10u w=10u
MQ15 t2 cell2_qn vdd vdd __Q15 l=10u w=10u
MQ18 cell2_qn t2 0 0 __Q18 l=10u w=10u
MQ17 cell2_qn t2 vdd vdd __Q17 l=10u w=10u
MQ19 bl wl3 t3 0 __Q19 l=10u w=10u
MQ20 cell3_qn wl3 bln 0 __Q20 l=10u w=10u
MQ22 t3 cell3_qn 0 0 __Q22 l=10u w=10u
MQ21 t3 cell3_qn vdd vdd __Q21 l=10u w=10u
MQ24 cell3_qn t3 0 0 __Q24 l=10u w=10u
MQ23 cell3_qn t3 vdd vdd __Q23 l=10u w=10u
MQ26 an a 0 0 __Q26 l=10u w=10u
MQ25 an a vdd vdd __Q25 l=10u w=10u
MQ28 bn b 0 0 __Q28 l=10u w=10u
MQ27 bn b vdd vdd __Q27 l=10u w=10u
MQ29 t0 an n0 0 __Q29 l=10u w=10u
MQ30 n0 a t0 vdd __Q30 l=10u w=10u
MQ31 t1 a n0 0 __Q31 l=10u w=10u
MQ32 n0 an t1 vdd __Q32 l=10u w=10u
MQ33 t2 an n1 0 __Q33 l=10u w=10u
MQ34 n1 a t2 vdd __Q34 l=10u w=10u
MQ35 t3 a n1 0 __Q35 l=10u w=10u
MQ36 n1 an t3 vdd __Q36 l=10u w=10u
MQ37 n0 bn yi 0 __Q37 l=10u w=10u
MQ38 yi b n0 vdd __Q38 l=10u w=10u
MQ39 n1 b yi 0 __Q39 l=10u w=10u
MQ40 yi bn n1 vdd __Q40 l=10u w=10u
MQ42 buffer_mid yi 0 0 __Q42 l=10u w=10u
MQ41 buffer_mid yi vdd vdd __Q41 l=10u w=10u
MQ44 y buffer_mid 0 0 __Q44 l=10u w=10u
MQ43 y buffer_mid vdd vdd __Q43 l=10u w=10u
.end
